# Ansys Electronics Desktop project, version 2025.2
materials:
  vacuum: permittivity=1
  copper: permeability=0.999991 conductivity=58000000

design Maxwell2DDesign1 (Maxwell 2D, Magnetostatic, about Z geometry, model units mm)
geometry:
  Polyline1 = polyline(y=0mm, xz in mm: (11000, 0) (7778.1746, 7778.1746) (6.7355574e-13, 11000), AngularArc from point 0 over 3 centre=(0mm, 0mm, 0mm) angle=90deg plane=ZX)
  Polyline2 = polyline(y=0mm, xz in mm: (10000, 0) (7071.0678, 7071.0678) (6.123234e-13, 10000), AngularArc from point 0 over 3 centre=(0mm, 0mm, 0mm) angle=90deg plane=ZX)
  Polyline3 = polyline((11000mm, 0mm, 0mm) (10000mm, 0mm, 0mm))
  Polyline4 [copper] = polyline((0mm, 0mm, 10000mm) (0mm, 0mm, 11000mm))
  Polyline4.unite(Polyline2, Polyline1, Polyline3)
  Polyline4.cover_lines()
  Region [vacuum] = region(percentage_offset: +X=100, -X=100, +Y=0, -Y=0, +Z=100, -Z=100)
boundaries and excitations:
  Balloon1: Balloon Edges=Region.edge(at (11000, 0, 22000), at (22000, 0, 5500), at (11000, 0, -11000))
  Polyline4: Coil Objects=Polyline4 Conductor_number=2000 Winding=Winding1 PolarityType=Positive
  Winding1: Winding Group Type=Current IsSolid=false Current=1000A ParallelBranchesNum=1
setups:
  Setup1: Magnetostatic MaximumPasses=10 MinimumPasses=2 MinimumConvergedPasses=1 PercentRefinement=30 PercentError=1 NonLinearResidual=0.0001
field plots:
  Mag_B1: B over Region on Setup1 : LastAdaptive
